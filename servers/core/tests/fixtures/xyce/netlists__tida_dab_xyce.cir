* Xyce translation of modela reference tool/TIDA-010954-v0-6_4 - Copie.a reference tool
* Generated by xyce_conversion/gen_xyce_netlist.py.
*
* Scope of conversion:
* - LV 40 V full bridge, leakage inductor, ideal transformer N=3.5.
* - HV/ac-side active bridge against a 230 Vrms/50 Hz source.
* - a reference tool C-Script control translated to Verilog-A tida_dab_controller.
* - a reference tool Modulator/ePWM blocks translated to Verilog-A tida_modulator.
* - TI GaN library devices approximated by Verilog-A switch + Coss models.

.param VAC_NOM=230
.param VDC_NOM=40
.param VGRID_PK={sqrt(2)*VAC_NOM}
.param FAC=50
.param CAC=4e-6
.param LK=3.6e-6
.param NTR=3.5
.param FSW0=300e3
.param TDT_PRI=20e-9
.param TDT_SEC=40e-9
.param FCTRL=40e3
.param TSTOP=8.30000000e-03
.param MAXSTEP=2.00000000e-07

* Sources and references from the a reference tool initialization commands.
VDC_SRC vdc_p 0 DC {VDC_NOM}
RDC_BLEED vdc_p 0 1e9
VGRID grid_p 0 SIN(0 {VGRID_PK} {FAC} 0 0 0)
RGRID grid_p ac_p 50m

* Current reference: a reference tool Power reference 600 W -> 300 W at 20 ms.
* The original schematic divides power by instantaneous Vac. That is singular
* at the AC zero crossing in a SPICE operating point, so this Xyce startup deck
* uses the equivalent bounded sinusoidal current command plus the Cac feed-forward.
BPLL pll 0 V={sin(2*3.141592653589793*FAC*TIME)}
BIREF i_ref 0 V={(600*(1-0.5*(1+tanh((TIME-20m)/1u)))+300*(0.5*(1+tanh((TIME-20m)/1u))))/VAC_NOM*1.41421356237*sin(2*3.141592653589793*FAC*TIME) + 100*3.141592653589793*VAC_NOM*1.41*CAC/2*sin(2*3.141592653589793*FAC*TIME-3.141592653589793/2)}

* Low-voltage bridge controller and modulator. fk_mhz matches C-Script output.
* Translated C-Script TPS controller.
* The PI state is maintained internally using $abstime-gated discrete update.
Ytida_dab_controller yctrl d1 d2 fk_mhz mode d2_pi is0 is1 is2 d1_comp d2_comp 0 i_ref pll i_grid v_ac_sense vdc_sense
Ytida_modulator ymod q1g q2g q3g q4g s1ag s1bg s2ag s2bg carrier 0 d2 d1 td_bus fk_mhz pll
VTD td_bus 0 DC 0
BVDCS vdc_sense 0 V={V(vdc_p)}
BVACS v_ac_sense 0 V={V(ac_p)}
R_D1 d1 0 1e12
R_D2 d2 0 1e12
R_FK fk_mhz 0 1e12
R_MODE mode 0 1e12
R_D2PI d2_pi 0 1e12
R_IS0 is0 0 1e12
R_IS1 is1 0 1e12
R_IS2 is2 0 1e12
R_D1COMP d1_comp 0 1e12
R_D2COMP d2_comp 0 1e12
R_CARRIER carrier 0 1e12
R_Q1G q1g 0 1e12
R_Q2G q2g 0 1e12
R_Q3G q3g 0 1e12
R_Q4G q4g 0 1e12
R_S1AG s1ag 0 1e12
R_S1BG s1bg 0 1e12
R_S2AG s2ag 0 1e12
R_S2BG s2bg 0 1e12
R_LVA lv_a 0 1e9
R_LVB lv_b 0 1e9
R_TANKP tank_p 0 1e9
R_PRIP pri_p 0 1e9
R_PRIN pri_n 0 1e9
R_SECP sec_p 0 1e9
R_SECN sec_n 0 1e9
R_HVA hv_a 0 1e9
R_HVB hv_b 0 1e9
R_ACP ac_p 0 1e9

* Primary LV full bridge. LMG2100R026 a reference tool Ron default is 2.6 mOhm.
Ytida_gan_switch yq1 vdc_p lv_a q1g RON=2.6m COSS=881p
Ytida_gan_switch yq2 lv_a 0 q2g RON=2.6m COSS=881p
Ytida_gan_switch yq3 vdc_p lv_b q3g RON=2.6m COSS=881p
Ytida_gan_switch yq4 lv_b 0 q4g RON=2.6m COSS=881p
RPRI lv_a tank_p 100u
LLEAK tank_p pri_p {LK} IC=0
RPRI1 pri_n lv_b 100u

* Transformer approximation for Xyce startup robustness. The a reference tool transformer
* has n=[1 N] and Lm=inf; a tightly coupled pair avoids an ideal E/F source loop.
LPRI pri_p pri_n 1u IC=0
LSEC sec_p sec_n {NTR*NTR*1u} IC=0
KTR LPRI LSEC 0.9999
RSEC_P sec_p hv_a 1m
RSEC_N sec_n hv_b 1m
R_PRI_SHUNT pri_p pri_n 1e9
R_SEC_SHUNT sec_p sec_n 1e9

* Secondary/HV active bridge. LMG3650R025 a reference tool Ron default is 25 mOhm.
Ytida_gan_switch ys1a ac_p hv_a s1ag RON=25m COSS=458p
Ytida_gan_switch ys1b hv_a ac_n s1bg RON=25m COSS=458p
Ytida_gan_switch ys2a ac_p hv_b s2ag RON=25m COSS=458p
Ytida_gan_switch ys2b hv_b ac_n s2bg RON=25m COSS=458p

* AC-side split capacitors/resistors from the a reference tool schematic.
RAC_TOP ac_p ctop 100u
CTOP ctop hv_b {CAC} IC=0
RAC_BOT hv_b cbot 100u
CBOT cbot ac_n {CAC} IC=0
RAC_REF ac_n 0 1m

* Measurements used by translated controller and report plots.
BIGRID i_grid 0 V={-I(VGRID)}

.options TIMEINT METHOD=Gear MAXORD=2 ABSTOL=1e-4 RELTOL=0.001
.options NONLIN-TRAN MAXSTEP=200 MAXSEARCHSTEP=20
.options OUTPUT INITIAL_INTERVAL=2.00000000e-07

.print TRAN FORMAT=PROBE
+ V(vdc_p) V(ac_p) V(ac_n) V(grid_p) I(VGRID) V(i_ref) V(d1) V(d2) V(fk_mhz) V(mode)
+ V(q1g) V(q2g) V(q3g) V(q4g) V(s1ag) V(s1bg) V(s2ag) V(s2bg)
+ V(lv_a) V(lv_b) V(hv_a) V(hv_b) V(pri_p) V(pri_n) V(sec_p) V(sec_n) I(LLEAK) V(i_grid)
+ V(d2_pi) V(is0) V(is1) V(is2)
+ V(ctop) V(cbot) I(LPRI) I(LSEC) V(tank_p) V(pll) V(i_ref) V(vdc_sense) V(v_ac_sense)

.tran {MAXSTEP} {TSTOP} 0 {MAXSTEP} UIC
.end
